* RC low-pass AC analysis: R=1k, C=100n
V1 in 0 AC 1
R1 in out 1k
C1 out 0 100n
.ac dec 200 10 100k
.meas AC cutoff_hz WHEN mag(V(out))=0.7071067811865476 FALL=1
.meas AC gain_1k FIND mag(V(out)) AT=1k
.end
